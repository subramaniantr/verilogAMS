//Verilog-AMS HDL for "tirunels_design", "veri_dac_copy" "verilogams"

`include "constants.vams"
`include "disciplines.vams"

module veri_dac(out,in,clk);
//Verilog-AMS HDL for "tirunels_design", "veri_dac" "verilogams"

parameter integer bits = 8 from [1:24]; //Default 8 bit
parameter real fullscale = 1.0; // output range is from 0 - 1V
parameter real td = 0p;
parameter real tt =10p;
parameter vdd = 1.0;
parameter real thresh = vdd /2;
parameter integer dir = 1 from [-1:1] exclude 0;

output out;
input clk;
input [bits-1:0]in;
electrical out, clk;
electrical [bits-1:0]in;

real aout;
integer weight;
genvar i;

analog begin
@(initial_step)
   begin
        aout = 0;
        weight = 2;
   end

@(cross(V(clk) - thresh, dir))
          begin
     aout = 0;
     weight = 2;
          for(i= bits-1;i>=0;i=i-1)
               begin
                   if(V(in[i]) > thresh) begin
                      aout = aout + fullscale/weight;
                   end
                   weight = weight*2;

               end
          end

         V(out) <+ transition(aout,td,tt);
end
endmodule
